addrmap csr {
    reg {
        name = "data processing increment register";
        field { sw = rw; hw = r;} increment[31:0] = 0;
    } INCREMENT @ 0x00;
};
