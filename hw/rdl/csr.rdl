addrmap csr {

    reg {
        name = "data_generator enable register";

        field {
            sw = rw;
            hw = r;
        } enable[0:0] = 0;

    } DG_ENABLE @ 0x00;

    reg {
        name = "data_generator length register";

        field {
            sw = rw;
            hw = r;
        } length[31:0] = 0;

    } DG_LENGTH @ 0x04;

    reg {
        name = "data source select register";
        desc = "Selects data source for DMA: 0=DG, 1=external module";

        field {
            sw = rw;
            hw = r;
        } sel[0:0] = 0;

    } SEL @ 0x08;

};
